###############################################################################
## SPDX-FileCopyrightText: 2024 CERN (home.cern)
##
## SPDX-License-Identifier: LGPL-2.1-or-later, CERN-OHL-W-2.0+
###############################################################################
##############################################################################;
## Title      : Auxclock Register Block
## Project    : White Rabbit
##############################################################################;
## File       : auxclk_regs.cheby
## Author     : Harvey Leicester
## Company    : CERN BE-CEM-EDL
## Created    : 2024-11-04
## Last update: 2024-11-04
##############################################################################
## Description: register interface for auxclock generator
##############################################################################
memory-map:
  name: auxclk_gen
  description: Auxclock register block
  bus: wb-32-be
  x-hdl:
    iogroup: auxclk_regs
    busgroup: True
    name-suffix: _regs
  schema-version:
    core: 2.0.0
    x-conversions: 1.0.0
    x-hdl: 1.0.0
    x-map-info: 1.0.0
    x-wbgen: 1.0.0
  children:
  - reg:
      name: PR
      description: Period Register
      width: 32
      access: rw
      address: 0x0
      x-hdl:
        write-strobe: True
        type: wire
      children:
      - field:
          name: hp_width
          description: Half period width, defined as number of 2ns cycles
          range: 15-0
  - reg:
      name: DCR
      description: Duty Cycle Register
      width: 32
      access: rw
      x-hdl:
        write-strobe: True
        type: wire
      children:
      - field:
          name: low_width
          description: Low state width, defined as number of 2ns cycles
          range: 15-0
