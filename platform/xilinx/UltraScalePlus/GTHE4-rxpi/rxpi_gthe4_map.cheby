memory-map:
  bus: wb-32-le
  name: rxpi_gthe4_map
  description: Memmap to control gthe4 for rxpi
  x-hdl:
    busgroup: True
  children:
  - reg:
     name: id
     comment: magic number to check presence
     width: 32
     access: ro
     preset: 0x000618e4
     x-hdl:
       type: const
  - reg:
     name: reset
     comment: Reset register
     width: 32
     access: rw
     children:
     - field:
         name: gth_rx_pma_rst
         comment: reset RX PMA for a different position
         range: 0
     - field:
         name: gth_rst
         range: 1
     - field:
         name: gth_tx_rst
         range: 2
     - field:
         name: gth_tx_pcs_rst
         range: 3
     - field:
         name: gth_tx_pma_rst
         range: 4
     - field:
         name: gth_rx_rst
         range: 5
     - field:
         name: gth_rx_pcs_rst
         range: 6
     - field:
         name: gth_rx_buf_rst
         range: 7
     - field:
         name: rxpi_rst
         range: 16
  - reg:
     name: status
     width: 32
     access: ro
     children:
     - field:
        name: phy_ready
        comment: serdes ready (reset and bypass done) and bitslide done
        range: 0
     - field:
        name: extra
        range: 31-16
  - reg:
     name: ctrl
     width: 32
     access: rw
     children:
     - field:
         name: rdy
         comment: Transceiver is fully ready
         range: 0
  - reg:
     name: bitslide
     comment: Bitslide
     width: 32
     access: ro
  - reg:
     name: rxpi_nsamp
     width: 32
     access: rw
     preset: 0x00007fff
  - reg:
     name: rxpi_shift
     width: 32
     access: rw
     preset: 0
  - reg:
     name: ps_ctrl
     comment: Control for phase shift
     width: 32
     access: rw
     x-hdl:
       write-strobe: True
     children:
     - field:
        name: rst
        range: 0
     - field:
        name: pd
        range: 1
     - field:
        name: incdec
        range: 8
     - field:
        name: shift
        range: 9
        x-hdl:
          type: wire
  - reg:
     name: ps_stat
     comment: Status for phase shift
     width: 32
     access: ro
     children:
     - field:
        name: phase
        range: 15-0
     - field:
        name: fb_stopped
        range: 16
     - field:
        name: in_stopped
        range: 17
     - field:
        name: locked
        range: 18
     - field:
        name: ps_busy
        range: 19
  - reg:
     name: ps_count
     comment: Number of sampling for ps
     width: 32
     access: wo
     children:
     - field:
        name: val
        range: 23-0
  - reg:
     name: ps_res
     comment: Number of sampling for ps
     width: 32
     access: ro
     children:
     - field:
        name: val
        range: 23-0
     - field:
        name: gen
        range: 31-24
  - reg:
     name: txpi_ctrl
     comment: TX phase interpolator (TXPIPPM) control
     width: 32
     access: rw
     children:
     - field:
        name: en
        comment: TXPIPPMEN - enable TX PI PPM stepping
        range: 0
     - field:
        name: ovrden
        comment: TXPIPPMOVRDEN - override enable
        range: 1
     - field:
        name: pd
        comment: TXPIPPMPD - power down
        range: 2
     - field:
        name: sel
        comment: TXPIPPMSEL - select
        range: 3
        preset: 1
     - field:
        name: stepsize
        comment: TXPIPPMSTEPSIZE
        range: 8-4
        preset: 0x11
  - reg:
     name: txpi_step
     comment: Issue a counted TXPIPPMEN pulse of <nsteps> clk_62m5 cycles
     width: 32
     access: rw
     x-hdl:
       write-strobe: True
     children:
     - field:
        name: nsteps
        range: 23-0
  - reg:
     name: txpi_stat
     comment: TXPI counted-pulse status
     width: 32
     access: ro
     children:
     - field:
        name: busy
        comment: counted pulse in progress
        range: 0
