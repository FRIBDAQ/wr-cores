memory-map:
  bus: axi4-lite-32
  name: mpsoc_map
  description: Memmap from mpsoc
  children:
  - submap:
     name: wrpc
     interface: wb-32-be
     size: 4k
     address: 0x0000
     x-hdl:
       busgroup: True
  - reg:
      name: ctrl
      comment: control register
      address: 0x1000
      width: 32
      access: rw
      children:
      - field:
          name: led1
          range: 0
      - field:
          name: led2
          range: 1
      - field:
          name: gth_rst
          range: 2
      - field:
          name: gth_tx_rst
          range: 4
      - field:
          name: gth_tx_pcs_rst
          range: 5
      - field:
          name: gth_tx_pma_rst
          range: 6
      - field:
          name: gth_rx_rst
          range: 8
      - field:
          name: gth_rx_pcs_rst
          range: 9
      - field:
          name: gth_rx_pma_rst
          range: 10
      - field:
          name: gth_rx_buf_rst
          range: 11
  - reg:
     name: status
     width: 32
     access: ro
  - reg:
     name: qpll0_sdm
     width: 32
     access: rw
     x-hdl:
       write-strobe: True
  - reg:
     name: qpll1_sdm
     width: 32
     access: rw
     x-hdl:
       write-strobe: True
  - reg:
     name: rxpi_samp
     comment: number of rxpi samples to accumulate
     width: 32
     access: rw
     preset: 0x3fff
  - reg:
     name: fifo_ctrl
     width: 32
     access: rw
     children:
     - field:
        name: en
        range: 0
  - reg:
     name: fifo_rdcount
     width: 32
     access: ro
  - reg:
     name: fifo_nfull
     comment: number of samples discarded because fifo was full, write to clear
     width: 32
     access: rw
     x-hdl:
       type: wire
       write-strobe: True
  - reg:
     name: fifo_data
     width: 32
     access: ro
     x-hdl:
       read-strobe: True
