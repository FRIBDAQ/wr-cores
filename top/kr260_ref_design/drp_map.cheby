memory-map:
  bus: wb-32-be
  name: drp_map
  comment: Interface for Xilinx GTH dynamic reconfiguration port
  x-hdl:
    busgroup: True
  children:
  - reg:
      name: addr
      comment: Address
      width: 16
      access: rw
  - reg:
      name: control
      comment: Data and control
      width: 32
      access: rw
      x-hdl:
        type: wire
        write-strobe: True
      children:
      - field:
          name: data
          comment: Data (read or write)
          range: 15-0
      - field:
          name: rdy
          comment: Set when a new transaction is possible
          range: 16
      - field:
          name: we
          comment: 1 for write, 0 for read
          range: 17
      - field:
          name: en
          comment: Set to start a transaction, always read as 0.
          range: 18
      - field:
          name: rst
          comment: Set for reset, always read as 0.
          range: 19

